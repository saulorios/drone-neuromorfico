* Neuronio com fome de corrente via ESPELHO (transistor = limitador, nao forcador)
* A fonte ideal fica no ramo de referencia, onde o transistor diodo SEMPRE conduz.
* Nao ha violacao de trilho possivel: o espelho de saida e um transistor real.
.param IB = __IB__

Vdd1 vdd1 0 1.8
Vdd2 vdd2 0 1.8
Vddr vddr 0 1.8

* --- ramo de referencia (compartilhado entre neuronios num chip real) ---
Irefn vddr rn DC {IB}
Mrefn rn rn 0 0 NMOS W=0.5u L=10u
Irefp rp 0 DC {IB}
Mrefp rp rp vddr vddr PMOS W=0.5u L=10u

* --- neuronio ---
Iin 0 mem DC __IIN__
Cmem mem 0 100f
Mbp sp1 rp vdd1 vdd1 PMOS W=0.5u L=10u
M1p n1  mem sp1 vdd1 PMOS W=2u L=0.5u
M1n n1  mem sn1 0    NMOS W=1u L=0.5u
Mbn sn1 rn 0 0 NMOS W=0.5u L=10u
M2p out n1  vdd2 vdd2 PMOS W=4u L=0.5u
M2n out n1  0    0    NMOS W=2u L=0.5u
Cfb out mem 20f
Mrst mem out 0 0 NMOS W=0.5u L=2u
Cload out 0 5f

.include spice/models/generic_l1.mod
.options abstol=1e-15 vntol=1e-9 reltol=1e-4 gmin=1e-15 chgtol=1e-16
+ trtol=1
.ic v(mem)=0 v(out)=0

.control
set filetype=ascii
tran __TS__ __TSTOP__ 0 __TS__ uic
wrdata __OUT__ v(mem) v(out) v(n1) v(sp1) v(sn1) i(vdd1) i(vdd2)
.endc
.end
