* fi_10p - espelho assimetrico (so PMOS) nos dois estagios
Vdd1 vdd1 0 1.8
Vdd2 vdd2 0 1.8
Vddr vddr 0 1.8

* --- ramos de referencia (compartilhados num chip real; fora do orcamento) ---
Iref1 rp1 0 DC 10n
Mref1 rp1 rp1 vddr vddr PMOS W=0.5u L=10u
Iref2 rp2 0 DC 3u
Mref2 rp2 rp2 vddr vddr PMOS W=5u L=1u

* --- neuronio ---
Iin 0 mem DC 10p
Cmem mem 0 100f
Mbp1 sp1 rp1 vdd1 vdd1 PMOS W=0.5u L=10u
M1p  n1  mem sp1  vdd1 PMOS W=2u L=0.5u
M1n  n1  mem 0    0    NMOS W=1u L=0.5u
Mbp2 sp2 rp2 vdd2 vdd2 PMOS W=5u L=1u
M2p  out n1  sp2  vdd2 PMOS W=4u L=0.5u
M2n  out n1  0    0    NMOS W=2u L=0.5u
Cfb out mem 20f
Mrst mem out 0 0 NMOS W=0.5u L=2u
Cload out 0 5f

.include spice/models/generic_l1.mod
.options abstol=1e-15 vntol=1e-9 reltol=1e-4 gmin=1e-15 chgtol=1e-16
+ trtol=1
.nodeset v(rp1)=1.2557 v(rp2)=1.1867
.ic v(mem)=0 v(out)=0
.control
set filetype=ascii
tran 0.5u 150m 0 0.5u uic
wrdata resultados/2026-09-07_fi_espelho/raw/fi_10p.txt v(mem) v(out) v(n1) v(sp1) v(sp2) v(rp1) v(rp2) i(vdd1) i(vdd2) i(vddr)
.endc
.end
