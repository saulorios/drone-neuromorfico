* B_com_u : nfet_01v8 isolado, Vgs = Vds = 1,8 V, canto tt, 27 C
.lib spice/models/sky130/sky130A/libs.tech/ngspice/sky130.lib.spice tt
.option scale=1u
Vd d 0 1.8
Vg g 0 1.8
Vb b 0 0
XM1 d g 0 b sky130_fd_pr__nfet_01v8 W=1u L=0.15u
.options abstol=1e-15 vntol=1e-9 reltol=1e-4 gmin=1e-15
.control
op
print i(Vd)
.endc
.end
