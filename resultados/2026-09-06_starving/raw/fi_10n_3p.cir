* fi_10n_3p
Vdd1 vdd1 0 1.8
Vdd2 vdd2 0 1.8
Iin 0 mem DC 3p
Cmem mem 0 100f
Ibp vdd1 sp1 DC 10n
Ibn sn1 0    DC 10n
M1p n1  mem sp1 vdd1 PMOS W=2u L=0.5u
M1n n1  mem sn1 0    NMOS W=1u L=0.5u
M2p out n1  vdd2 vdd2 PMOS W=4u L=0.5u
M2n out n1  0    0    NMOS W=2u L=0.5u
Cfb out mem 20f
Mrst mem out 0 0 NMOS W=0.5u L=2u
Cload out 0 5f
.include spice/models/generic_l1.mod
.options abstol=1e-15 vntol=1e-9 reltol=1e-4 gmin=1e-15 chgtol=1e-16
+ trtol=1
.ic v(mem)=0 v(out)=0
.control
set filetype=ascii
tran 0.5u 400m 0 0.5u uic
wrdata resultados/2026-09-06_starving/raw/fi_10n_3p.txt v(mem) v(out) v(n1) i(vdd1) i(vdd2)
.endc
.end
